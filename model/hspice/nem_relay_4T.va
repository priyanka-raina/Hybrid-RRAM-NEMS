/*******************************************************************
    Simple lumped 4T NEM Relay Model

    Adapted from:
    Chong, Soogine, Kerem Akarvardar, Roozbeh Parsa, Jun-Bo Yoon,
    Roger T. Howe, Subhasish Mitra, and H-S. Philip Wong.
    "Nanoelectromechanical (NEM) relays integrated with CMOS SRAM
    for improved stability and low leakage." In Proceedings of the
    2009 International Conference on Computer-Aided Design, pp.
    478-484. ACM, 2009.

    Author: Akash Levy
    Model name: nem_relay_4T.va
*******************************************************************/

module NEM_4T(drain, gate, source, bridge);
    // Input variable definition
    parameter real Vpi = 0.8;                   // pull-in voltage
    parameter real Vpo = 0.2;                   // pull-out voltage
    parameter real rch = 1e+3 from [0:inf);     // resistance
    parameter real tdmec = 1e-9;                // mechanical delay
    parameter real tr = 1e-18;                  // small nonzero value
    parameter real tf = 1e-18;                  // small nonzero value
    parameter real Cgbon = 2e-17;               // on-capacitance
    parameter real Cgboff = 1.5e-17;            // off-capacitance
    parameter real on_i = 0;                    // device initially on?

    real on_flg = 0;                            // "1" when device is on
    real Vgb;
    real Cgb;
    real td;                                    // switching delay
    inout drain, gate, source, bridge;
    electrical drain, gate, source, bridge;
    analog begin
        // Initialization
        @(initial_step("tran","dc")) begin
            on_flg = on_i;
            td = tdmec;
        end

        Vgb = abs(V(gate,bridge));

        if ((Vgb >= Vpi) && (on_flg == 0)) begin
            on_flg = 1;
            Cgb = Cgbon;
            td = tdmec;
        end
        else if ((Vgb > Vpo) && (on_flg == 1)) begin
            on_flg = 1;
            Cgb = Cgbon;
            td = tdmec;
        end
        else if ((Vgb <= Vpo) && (on_flg == 1)) begin
            on_flg = 0;
            Cgb = Cgboff;
            td = 0;
        end
        else if ((Vgb < Vpi) && (on_flg == 0)) begin
            on_flg = 0;
            Cgb = Cgboff;
            td = 0;
        end

        I(drain,source) <+ transition(on_flg,td,tr,tf) * V(drain,source) / rch;
        I(gate,bridge) <+ (transition(on_flg,0,td,tf) * (Cgbon-Cgboff)+Cgboff) * ddt(V(gate,bridge));
    end // end of analog begin
endmodule
