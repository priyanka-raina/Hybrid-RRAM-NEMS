/*******************************************************************
    RRAM-actuated 4T NEM relay

    Author: Akash Levy
    Model name: 4T_hybrid.va
*******************************************************************/

`include "nem_relay_4T.va"
`include "rram_simple.va"

module Hybrid_4T(row, col, source, drain);
    // NEM relay input variable definition
    parameter real Vpi = 0.8;                   // pull-in voltage
    parameter real Vpo = 0.2;                   // pull-out voltage
    parameter real rch = 1e+3 from [0:inf);     // resistance
    parameter real tdmec = 1e-9;                // mechanical delay
    parameter real tr = 1e-18;                  // small nonzero value
    parameter real tf = 1e-18;                  // small nonzero value
    parameter real Cgbon = 2e-17;               // on-capacitance
    parameter real Cgboff = 1.5e-17;            // off-capacitance

    // RRAM input variable definition
    parameter real Vset = 1.5;                  // SET voltage (HRS->LRS)
    parameter real Vrst = -1.5;                 // RESET voltage (LRS->HRS)
    parameter real Rl = 1000;                   // resistance (Ohms)
    parameter real Rh = 10000;                  // resistance (Ohms)
    parameter real on_i = 0;                    // initially LRS or HRS?

    inout row, col, source, drain;
    electrical row, col, source, drain;

    // Connect components
    RRAM #(.Vpi(0.8), .Vpo(0.2), .rch(1e+3), .tdmec(1e-9), .tr(1e-18), .tf(1e-18), .Cgbon(2e-17), .Cgboff(1.5e-17)) R1(row, gate);
    RRAM #(.Vpi(0.8), .Vpo(0.2), .rch(1e+3), .tdmec(1e-9), .tr(1e-18), .tf(1e-18), .Cgbon(2e-17), .Cgboff(1.5e-17)) R2(col, gate);
    NEM_4T #(.Vset(1.5), .Vrst(-1.5), .Rl(1000), .Rh(10000), .on_i(0)) NEM(drain, gate, source, gnd);

endmodule
